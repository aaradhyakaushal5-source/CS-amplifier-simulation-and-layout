* Extracted by KLayout with SKY130 LVS runset on : 18/07/2026 14:12

* cell CS
* pin CURR
* pin VDD
* pin VIN
* pin VO
* pin VSS
.SUBCKT CS CURR VDD VIN VO VSS
* device instance $1 r270 *1 -24.205,237.315 sky130_fd_pr__nfet_01v8
XM$1 VO VIN VSS VSS sky130_fd_pr__nfet_01v8 L=1000000 W=349925000
+ AS=9.09805e+13 AD=9.09805e+13 PS=422510000 PD=422510000
* device instance $6 r90 *1 351.17,244.685 sky130_fd_pr__pfet_01v8
XM$6 VDD CURR VO VDD sky130_fd_pr__pfet_01v8 L=1000000 W=8189250000
+ AS=2.08825875e+15 AD=2.08825875e+15 PS=9013275000 PD=9013275000
* device instance $16 r90 *1 351.17,273.525 sky130_fd_pr__pfet_01v8
XM$16 VDD CURR CURR VDD sky130_fd_pr__pfet_01v8 L=1000000 W=8189250000
+ AS=2.08825875e+15 AD=2.08825875e+15 PS=9013275000 PD=9013275000
.ENDS CS
