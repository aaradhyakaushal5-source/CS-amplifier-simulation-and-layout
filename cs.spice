.subckt CS CURR VDD VIN VO VSS
*.PININFO VDD:I VIN:I VO:O VSS:B CURR:I
M1 VO VIN VSS VSS sky130_fd_pr__nfet_01v8 L=1 W=349.925
M2 CURR CURR VDD VDD sky130_fd_pr__pfet_01v8 L=1 W=8189.25
M3 VO CURR VDD VDD sky130_fd_pr__pfet_01v8 L=1 W=8189.25
.ends CS
